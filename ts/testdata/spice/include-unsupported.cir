* .include needs the file system, which the dialog does not have
.include models.lib
.subckt fromlib a
r1 a 0 1k
.ends
